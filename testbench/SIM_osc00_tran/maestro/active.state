ADE simulation setup
Test edtest00_SIM_osc00_tran_1: edtest00/SIM_osc00_tran/schematic, simulator spectre
  Models: /afs/ee.ust.hk/sun4x_56/usr/eelocal/tsmc_icdc/tsmc028/28HPCplus_RF/PDK/TSMC_iPDK/tn28crsp029w1_1_8_2p2a/SkillPc_RF_0p9_1p8_1P9M_6X1Z1U_UT_AlRDL_ind1z1u/tsmcN28/../models/spectre/toplevel.scs[TOP_TT]
  Variables: avdd = 1.8
  Temperature: 125
  Analysis tran: stop=20u errpreset=conservative
  Signals: /vpd, /I0/avdd (terminal), /clk
Run mode: Single Run, Sweeps and Corners
