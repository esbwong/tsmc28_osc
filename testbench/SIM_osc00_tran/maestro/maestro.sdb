ADE simulation setup
Run mode: Single Run, Sweeps and Corners
Tests:
  edtest00_SIM_osc00_tran_1: edtest00/SIM_osc00_tran/schematic, simulator spectre
    Variables: avdd = 1.8
